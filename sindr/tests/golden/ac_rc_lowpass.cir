ac: first-order RC low-pass, fc = 159.15 Hz
V1 in 0 0
R1 in out 1k
C1 out 0 1u
.end
