op: NMOS common-source (built in Rust on the sindr side)
VDD vdd 0 10
VG g 0 3
RD vdd d 10k
M1 d g 0 0 nmos1 W=1 L=1
* sindr default_nmos: KP=2e-4 VTO=0.7 LAMBDA=0.02 GAMMA=0.4 PHI=0.6
.model nmos1 NMOS(LEVEL=1 KP=2e-4 VTO=0.7 LAMBDA=0.02 GAMMA=0.4 PHI=0.6)
.end
