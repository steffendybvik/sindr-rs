op: high-side PMOS switch, source and body at VDD (built in Rust on the sindr side)
VDD vdd 0 10
VG g 0 5
M1 d g vdd vdd pmos1 W=1 L=1
RD d 0 10k
* sindr default_pmos: KP=1e-4 VTO=-0.7 LAMBDA=0.02 GAMMA=0.4 PHI=0.6
.model pmos1 PMOS(LEVEL=1 KP=1e-4 VTO=-0.7 LAMBDA=0.02 GAMMA=0.4 PHI=0.6)
.end
