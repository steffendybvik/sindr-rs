op: diode with series resistor
V1 in 0 5
R1 in out 1k
D1 out 0 dsi
* sindr's built-in silicon diode
.model dsi D(IS=1e-14 N=1)
.end
