tran: RC charging from 0 V, tau = 1 ms
V1 in 0 5
R1 in out 1k
C1 out 0 1u
.end
