* Synchronous buck, switched: 12 V to about 5 V at a fixed 5/12 duty,
* 200 kHz, into 5 ohms. ngspice only: sindr checks its averaged
* SwitchingRegulator against this over a period (tran_switched_buck).
vin in 0 12
* High side on for Ton = 5/12 of 5 us; low side for the rest.
vgh gh 0 pulse(0 5 0 1n 1n 2.08233333u 5u)
vgl gl 0 pulse(0 5 2.08433333u 1n 1n 2.91366667u 5u)
s1 in sw gh 0 sw
s2 sw 0 gl 0 sw
* Body diode: carries the inductor through the dead time.
d2 0 sw dbody
l1 sw lx 22u ic=1
rl lx out 30m
c1 out 0 100u ic=4.9
rload out 0 5
.model sw sw(vt=2.5 vh=0 ron=20m roff=1meg)
.model dbody d(is=1e-12 n=1)
.end
