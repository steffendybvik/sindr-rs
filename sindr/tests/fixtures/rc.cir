* RC low-pass test fixture
Vin in 0 DC 5
R1  in out 1k
C1  out 0 1u
.tran 1u 5m
.end
