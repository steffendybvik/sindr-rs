cycle b title
.include 'cycle_a.cir'
.end
