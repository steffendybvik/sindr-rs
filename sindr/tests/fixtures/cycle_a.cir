cycle a title
.include 'cycle_b.cir'
.end
